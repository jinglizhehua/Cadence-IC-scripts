hiSetBindKeys( "Schematics" list(list("<Key>9" "geEnterAddNetProbe()")))
hiSetBindKeys( "Schematics" list(list("<Key>space" "schZoomFit(1.0 1.0)")))
hiSetBindKeys( "Schematics" list(list("Ctrl<Btn4Down>" "hiZoomRelativeScale(hiGetCurrentWindow() 1.01)")))
hiSetBindKeys( "Schematics" list(list("Ctrl<Btn5Down>" "hiZoomRelativeScale(hiGetCurrentWindow() 0.99)")))
hiSetBindKeys( "Layout" list(list("None<Btn4Down>" "hiZoomInAtMouse()")))
hiSetBindKeys( "Layout" list(list("None<Btn5Down>" "hiZoomOutAtMouse()")))

hiSetBindKeys( "Symbol" list(list("<Key>space" "schZoomFit(1.0 1.0)")))
hiSetBindKeys( "Symbol" list(list("Ctrl<Btn4Down>" "hiZoomRelativeScale(hiGetCurrentWindow() 1.01)")))
hiSetBindKeys( "Symbol" list(list("Ctrl<Btn5Down>" "hiZoomRelativeScale(hiGetCurrentWindow() 0.99)")))
