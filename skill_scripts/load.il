printf("---------start load scripts------------\n")
printf("load display.drf\n")
drLoadDrf("/home/user014/scripts/display.drf")
printf("load bindkeyall.il\n")
load("/home/user014/scripts/bindkeyall.il")
printf("load bindkey.il\n")
load("/home/user014/scripts/bindkey.il")
printf("load delNetNames.il\n")
load("/home/user014/scripts/delNetNames.il")
printf("load pailie.il\n")
load("/home/user014/scripts/pailie.il")
printf("load readpin.il\n")
load("/home/user014/scripts/readpin.il")
printf("load use_list.il\n")
load("/home/user014/scripts/use_list.il")
printf("load move.il\n")
load("/home/user014/scripts/move.il")
printf("load cross_ruler.il\n")
load("/home/user014/scripts/cross_ruler.il")
printf("load replace_select.il\n")
load("/home/user014/scripts/replace_select.il")
printf("load myenv\n")
envLoadFile("/home/user014/scripts/myenv")
printf("----------load finished----------------\n")
printf("\n")
printf("______/\\\\\\\\\\\\\\\\\\\\\\_        __/\\\\\\_____________        __/\\\\\\\\\\\\\\\\\\\\\\\\\\\\\\_        __/\\\\\\________/\\\\\\_        \n")
printf(" _____\\/////\\\\\\///__        _\\/\\\\\\_____________        _\\////////////\\\\\\__        _\\/\\\\\\_______\\/\\\\\\_       \n")
printf("  _________\\/\\\\\\_____        _\\/\\\\\\_____________        ___________/\\\\\\/___        _\\/\\\\\\_______\\/\\\\\\_      \n")
printf("   _________\\/\\\\\\_____        _\\/\\\\\\_____________        _________/\\\\\\/_____        _\\/\\\\\\\\\\\\\\\\\\\\\\\\\\\\\\_     \n")
printf("    _________\\/\\\\\\_____        _\\/\\\\\\_____________        _______/\\\\\\/_______        _\\/\\\\\\/////////\\\\\\_    \n")
printf("     _________\\/\\\\\\_____        _\\/\\\\\\_____________        _____/\\\\\\/_________        _\\/\\\\\\_______\\/\\\\\\_   \n")
printf("      __/\\\\\\___\\/\\\\\\_____        _\\/\\\\\\_____________        ___/\\\\\\/___________        _\\/\\\\\\_______\\/\\\\\\_  \n")
printf("       _\\//\\\\\\\\\\\\\\\\\\______        _\\/\\\\\\\\\\\\\\\\\\\\\\\\\\\\\\_        __/\\\\\\\\\\\\\\\\\\\\\\\\\\\\\\_        _\\/\\\\\\_______\\/\\\\\\_ \n")
printf("        __\\/////////_______        _\\///////////////__        _\\///////////////__        _\\///________\\///__\n")
printf("\n")
