;;-----------------------------------------------------------------------------
;; Bindkeys for 'Schematics'
;; Inherited by:
;;             * PcellIDE Schematic
;;             * Power Manager
;;             * Schematics XL
;;             * adegxl-schematic
;;             * adexl-schematic
;;             * assembler-schematic
;;             * explorer-schematic
;;-----------------------------------------------------------------------------
hiSetBindKeys( "Schematics" list(
    list("<DrawThru1>"	"schDirectEdit(1)"	"geSingleSelectBox()")
    list("<DrawThru2>"	"hiDynamicPanGrabbing()"	"hiDynamicPanGrabbing()")
    list("<DrawThru3>"	"hiZoomIn()"	"hiZoomIn()")
    list("<Key>#"	"hiToggleAnchorMagnifier()")
    list("<Key>'"	"hiUpdateMagOptions()")
    list("<Key>."	"hiToggleMagnifier()")
    list("<Key>0"	"geDeleteNetProbe()")
    list("<Key>1"	"SetSnapMode()"	"SetSnapMode()")
    list("<Key>2"	"schHiRotate()")
    list("<Key>3"	"geDeleteAllProbe(getCurrentWindow() t)")
    list("<Key>4"	"schSetEnv(\"sideways\" t)")
    list("<Key>5"	"schSetEnv(\"upsideDown\" t)")
    list("<Key>7"	"EditInCopySch()")
    list("<Key>8"	"ProbeAllNet()")
    list("<Key>9"	"geEnterAddNetProbe()")
    list("<Key>="	"schHiOpenSymbolOrSchematicView(geGetEditCellView() hiGetCurrentWindow())")
    list("<Key>A"	"schHiMove()")
    list("<Key>B"	"schHiCreateBlockInst()")
    list("<Key>BackSpace"	"schHiDelete()"	"deletePoint()")
    list("<Key>C"	"schHiCopy()")
    list("<Key>D"	"geSubSelectPoint()")
    list("<Key>Delete"	"schHiDelete()")
    list("<Key>Down"	"geScroll(nil \"s\" nil)")
    list("<Key>E"	"schHiDescendRead()")
    list("<Key>Escape"	""	"cancelEnterFun()")
    list("<Key>F"	"schZoomFit(1.0 0.9)")
    list("<Key>F1"	"hiHelp('window deGetAppInfo(deGetEditViewType(hiGetCurrentWindow()))->appName)")
    list("<Key>F11"	"deToggleAssistants()")
    list("<Key>F3"	"geSaveAs()"	"hiToggleEnterForm()")
    list("<Key>F4"	"geTogglePartialSelect()")
    list("<Key>F6"	"hiRedraw()")
    list("<Key>G"	"schHiFindMarker()")
    list("<Key>H"	"schHiOpenCellView()")
    list("<Key>I"	"schHiCreateInst()")
    list("<Key>L"	"schHiCreateWireLabel()")
    list("<Key>Left"	"geScroll(nil \"w\" nil)")
    list("<Key>M"	"schHiStretch()")
    list("<Key>N"	"schHiCreateNoteShape()")
    list("<Key>O"	"schHiDisplayOptions()")
    list("<Key>P"	"schHiCreatePin()")
    list("<Key>Q"	"schHiObjectProperty()"	"schHiObjectProperty()")
    list("<Key>R"	"schHiCreateNoteLabel()"	"schSetEnv(\"sideways\" t)")
    list("<Key>Right"	"geScroll(nil \"e\" nil)")
    list("<Key>S"	""	"schSnapToConn()")
    list("<Key>T"	"schHiEditText()")
    list("<Key>U"	"hiUndo()")
    list("<Key>Up"	"geScroll(nil \"n\" nil)")
    list("<Key>V"	"hiVectorPan()")
    list("<Key>W"	"schHiCreateWire(0.0)")
    list("<Key>X"	"schHiCheck(\"run\")")
    list("<Key>Z"	"hiZoomIn()")
    list("<Key>["	"hiZoomRelativeScale(getCurrentWindow() 0.8)")
    list("<Key>]"	"hiZoomRelativeScale(getCurrentWindow() 1.25)")
    list("<Key>space"	"schZoomFit(1.0 1.0)")
    list("Ctrl Shift<Btn1Down>"	"hiZoomInMagnifier(hiGetCurrentWindow())")
    list("Ctrl Shift<Btn2Down>"	"hiZoomOutMagnifier(hiGetCurrentWindow())")
    list("Ctrl Shift<Btn4Down>"	"_schScaleMagnifier(1.25)")
    list("Ctrl Shift<Btn5Down>"	"_schScaleMagnifier(0.80)")
    list("Ctrl Shift<Key>A"	"schSelectByLine()")
    list("Ctrl Shift<Key>Down"	"hiScaleMagnifier(0.80)")
    list("Ctrl Shift<Key>Up"	"hiScaleMagnifier(1.25)")
    list("Ctrl Shift<Key>Z"	"hiNextWinView(hiGetCurrentWindow())")
    list("Ctrl<Btn1Down>"	"mouseSubSelectPt()"	"mouseSubSelectPt()")
    list("Ctrl<Btn4Down>"	"hiZoomRelativeScale(hiGetCurrentWindow() 1.01)")
    list("Ctrl<Btn5Down>"	"hiZoomRelativeScale(hiGetCurrentWindow() 0.99)")
    list("Ctrl<DrawThru1>"	"schDirectEdit(3)"	"geSubSelectBox()")
    list("Ctrl<Key>A"	"schSelectAllFig()")
    list("Ctrl<Key>B"	"annToggleInfoBalloonVisibilityStatus()")
    list("Ctrl<Key>C"	"mgc_rve_end_enter_function_binding(\"Schematics\")")
    list("Ctrl<Key>D"	"schDeselectAllFig()")
    list("Ctrl<Key>E"	"schHiReturn()")
    list("Ctrl<Key>F"	"schSetSelectOptions()")
    list("Ctrl<Key>F11"	"deToggleToolbars()")
    list("Ctrl<Key>G"	"geHiDeleteMarker()")
    list("Ctrl<Key>M"	"move()")
    list("Ctrl<Key>O"	"arrange()")
    list("Ctrl<Key>P"	"readpin()")
    list("Ctrl<Key>R"	""	"schSetEnv(\"upsideDown\" t)")
    list("Ctrl<Key>S"	"_schHiSaveAs()")
    list("Ctrl<Key>T"	"schHiZoomToSelSet()")
    list("Ctrl<Key>Tab"	"hiLowerWindow(hiGetCurrentWindow())")
    list("Ctrl<Key>V"	"hiFocusToCIW(hiGetCurrentWindow())")
    list("Ctrl<Key>Z"	"hiZoomOut()")
    list("Ctrl<Key>space"	"schHiDelete()")
    list("None<Btn1Down>"	"schSingleSelectPt()"	"mouseAddPt(t)")
    list("None<Btn1Down>(2)"	"schHiDefaultAction()"	"schMouseApplyOrFinish()")
    list("None<Btn2Down>"	"mousePopUp()"	"mouseFinishPt()")
    list("None<Btn3Down>"	"schHiMousePopUp()"	"schSetEnv(\"rotate\" t)")
    list("None<Btn3Down>(2)"	""	"hiToggleEnterForm()")
    list("None<Btn4Down>"	"hiZoomInAtMouse()")
    list("None<Btn5Down>"	"hiZoomOutAtMouse()")
    list("Return"	""	"schMouseApplyOrFinish()")
    list("Shift<Btn1Down>"	"schAddSelectPt()"	"mouseAddSelectPt()")
    list("Shift<Btn1Down>(2)"	"schExtendSelectPt()")
    list("Shift<Btn2Down>"	""	"schShiftCmdOption()")
    list("Shift<Btn4Down>"	"geScroll(nil \"w\" nil)")
    list("Shift<Btn5Down>"	"geScroll(nil \"e\" nil)")
    list("Shift<DrawThru1>"	"schDirectEdit(2)"	"geAddSelectBox()")
    list("Shift<DrawThru3>"	"hiZoomOut()"	"hiZoomOut()")
    list("Shift<Key>8"	"schHiHiliteLabel(\"instance\" \"off\")")
    list("Shift<Key>A"	"schSingleSelectBox()")
    list("Shift<Key>B"	"annPinCurrentInfoBalloon(hiGetCurrentWindow())")
    list("Shift<Key>D"	"schSubSelectBox()")
    list("Shift<Key>Delete"	"schHiIgnore()")
    list("Shift<Key>Down"	"move_down()")
    list("Shift<Key>E"	"schHiDescendEdit()")
    list("Shift<Key>F"	"hiZoomAbsoluteScale(getCurrentWindow() 0.9)")
    list("Shift<Key>F11"	"deToggleAssistants() deToggleToolbars()")
    list("Shift<Key>F4"	"geToggleAreaSelectOption()")
    list("Shift<Key>G"	"schHiFindMarker()")
    list("Shift<Key>H"	"schHiHiliteLabel(\"wire\" \"off\")")
    list("Shift<Key>L"	"schHiCreateNoteLabel()")
    list("Shift<Key>Left"	"move_left()")
    list("Shift<Key>M"	"schHiMove()")
    list("Shift<Key>N"	"schHiCreateNoteLabel()")
    list("Shift<Key>O"	"schHiEditorOptions()")
    list("Shift<Key>Q"	"schHiCellViewProperty()"	"schHiCellViewProperty()")
    list("Shift<Key>R"	""	"schSetEnv(\"sideways\" t)")
    list("Shift<Key>Right"	"move_right()")
    list("Shift<Key>S"	"schHiFind()")
    list("Shift<Key>T"	"schHiTree()")
    list("Shift<Key>U"	"hiRedo()")
    list("Shift<Key>Up"	"move_up()")
    list("Shift<Key>V"	"_deToggleAssistant(\"World View\")")
    list("Shift<Key>W"	"schHiCreateWire(schGetEnv(\"defWideWireWidth\"))")
    list("Shift<Key>X"	"schHiCheckAndSave()")
    list("Shift<Key>Z"	"hiPrevWinView(hiGetCurrentWindow())")
)) ;; hiSetBindKeys
;;-----------------------------------------------------------------------------
