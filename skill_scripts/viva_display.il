envSetVal("viva.trace" "lineThickness" 'string "ExtraThick")
envSetVal("viva.pointMarker" "font" 'string "Default, 18, -1, 5, 50, 0, 0, 0, 0, 0")
envSetVal("viva.refPointMarker" "font" 'string "Default, 18, -1, 5, 50, 0, 0, 0, 0, 0")
envSetVal("viva.horizMarker" "font" 'string "Default, 18, -1, 5, 50, 0, 0, 0, 0, 0")
envSetVal("viva.vertMarker" "font" 'string "Default, 18, -1, 5, 50, 0, 0, 0, 0, 0")
envSetVal("viva.multiDeltaMarker" "font" 'string "Default, 18, -1, 5, 50, 0, 0, 0, 0, 0")
envSetVal("viva.graphLabel" "font" 'string "Default, 18, -1, 5, 50, 0, 0, 0, 0, 0")
envSetVal("viva.traceLegend" "font" 'string "Default, 18, -1, 5, 50, 0, 0, 0, 0, 0")
envSetVal("viva.traceLegend" "printSaveImageFont" 'string "Default, 18, -1, 5, 50, 0, 0, 0, 0, 0")
envSetVal("viva.rectGraph" "legendPosition" 'string "left")
envSetVal("viva.rectGraph" "background" 'string "white")
envSetVal("viva.axis" "minorTicsOn" 'string "false")
envSetVal("viva.horizMarker" "interceptStyle" 'string "On")
envSetVal("viva.vertMarker" "interceptStyle" 'string "On")
envSetVal("viva.axis" "font" 'string "Default, 14, -1, 5, 50, 0, 0, 0, 0, 0")
