simulator lang=spectre insensitive=yes

section tt
include "/home/user014/model/YYKJ_model_from_24v2ag2s/018umDBSBCDG2S/work/Model/sb1816x52v05.scs" section=tt_ld_g5
include "/home/user014/model/YYKJ_model_from_24v2ag2s/018umDBSBCDG2S/work/Model/sb1816x52v05.scs" section=tt_esd
include "/home/user014/model/YYKJ_model_from_24v2ag2s/018umDBSBCDG2S/work/Model/sb1816x52v05.scs" section=tt_hv_g5
include "/home/user014/model/YYKJ_model_from_24v2ag2s/018umDBSBCDG2S/work/Model/sb1816x52v05.scs" section=restypical
include "/home/user014/model/YYKJ_model_from_24v2ag2s/018umDBSBCDG2S/work/Model/sb1816x52v05.scs" section=dztypical
include "/home/user014/model/YYKJ_model_from_24v2ag2s/018umDBSBCDG2S/work/Model/sb1816x52v05.scs" section=dsbtypical
include "/home/user014/model/YYKJ_model_from_24v2ag2s/018umDBSBCDG2S/work/Model/sb1816x52v05.scs" section=diotypical
include "/home/user014/model/YYKJ_model_from_24v2ag2s/018umDBSBCDG2S/work/Model/sb1816x52v05.scs" section=tt_5
include "/home/user014/model/YYKJ_model_from_24v2ag2s/018umDBSBCDG2S/work/Model/sb1816x52v05.scs" section=mcaptypical
include "/home/user014/model/YYKJ_model_from_24v2ag2s/018umDBSBCDG2S/work/Model/sb1816x52v05.scs" section=captypical
include "/home/user014/model/YYKJ_model_from_24v2ag2s/018umDBSBCDG2S/work/Model/sb1816x52v05.scs" section=biptypical
//include "/home/user014/model/YYKJ_model_from_24v2ag2s/018umDBSBCDG2S/work/Model/sb1816x52v05.scs" section=tt_1d8
endsection tt

section ff
include "/home/user014/model/YYKJ_model_from_24v2ag2s/018umDBSBCDG2S/work/Model/sb1816x52v05.scs" section=ff_ld_g5
include "/home/user014/model/YYKJ_model_from_24v2ag2s/018umDBSBCDG2S/work/Model/sb1816x52v05.scs" section=ff_esd
include "/home/user014/model/YYKJ_model_from_24v2ag2s/018umDBSBCDG2S/work/Model/sb1816x52v05.scs" section=ff_hv_g5
include "/home/user014/model/YYKJ_model_from_24v2ag2s/018umDBSBCDG2S/work/Model/sb1816x52v05.scs" section=resfast
include "/home/user014/model/YYKJ_model_from_24v2ag2s/018umDBSBCDG2S/work/Model/sb1816x52v05.scs" section=dzfast
include "/home/user014/model/YYKJ_model_from_24v2ag2s/018umDBSBCDG2S/work/Model/sb1816x52v05.scs" section=dsbfast
include "/home/user014/model/YYKJ_model_from_24v2ag2s/018umDBSBCDG2S/work/Model/sb1816x52v05.scs" section=diofast
include "/home/user014/model/YYKJ_model_from_24v2ag2s/018umDBSBCDG2S/work/Model/sb1816x52v05.scs" section=ff_5
include "/home/user014/model/YYKJ_model_from_24v2ag2s/018umDBSBCDG2S/work/Model/sb1816x52v05.scs" section=mcapfast
include "/home/user014/model/YYKJ_model_from_24v2ag2s/018umDBSBCDG2S/work/Model/sb1816x52v05.scs" section=capfast
include "/home/user014/model/YYKJ_model_from_24v2ag2s/018umDBSBCDG2S/work/Model/sb1816x52v05.scs" section=bipfast
//include "/home/user014/model/YYKJ_model_from_24v2ag2s/018umDBSBCDG2S/work/Model/sb1816x52v05.scs" section=ff_1d8
endsection ff

section ss
include "/home/user014/model/YYKJ_model_from_24v2ag2s/018umDBSBCDG2S/work/Model/sb1816x52v05.scs" section=ss_ld_g5
include "/home/user014/model/YYKJ_model_from_24v2ag2s/018umDBSBCDG2S/work/Model/sb1816x52v05.scs" section=ss_esd
include "/home/user014/model/YYKJ_model_from_24v2ag2s/018umDBSBCDG2S/work/Model/sb1816x52v05.scs" section=ss_hv_g5
include "/home/user014/model/YYKJ_model_from_24v2ag2s/018umDBSBCDG2S/work/Model/sb1816x52v05.scs" section=resslow
include "/home/user014/model/YYKJ_model_from_24v2ag2s/018umDBSBCDG2S/work/Model/sb1816x52v05.scs" section=dzslow
include "/home/user014/model/YYKJ_model_from_24v2ag2s/018umDBSBCDG2S/work/Model/sb1816x52v05.scs" section=dsbslow
include "/home/user014/model/YYKJ_model_from_24v2ag2s/018umDBSBCDG2S/work/Model/sb1816x52v05.scs" section=dioslow
include "/home/user014/model/YYKJ_model_from_24v2ag2s/018umDBSBCDG2S/work/Model/sb1816x52v05.scs" section=ss_5
include "/home/user014/model/YYKJ_model_from_24v2ag2s/018umDBSBCDG2S/work/Model/sb1816x52v05.scs" section=mcapslow
include "/home/user014/model/YYKJ_model_from_24v2ag2s/018umDBSBCDG2S/work/Model/sb1816x52v05.scs" section=capslow
include "/home/user014/model/YYKJ_model_from_24v2ag2s/018umDBSBCDG2S/work/Model/sb1816x52v05.scs" section=bipslow
//include "/home/user014/model/YYKJ_model_from_24v2ag2s/018umDBSBCDG2S/work/Model/sb1816x52v05.scs" section=ss_1d8
endsection ss

section fs
include "/home/user014/model/YYKJ_model_from_24v2ag2s/018umDBSBCDG2S/work/Model/sb1816x52v05.scs" section=fs_ld_g5
include "/home/user014/model/YYKJ_model_from_24v2ag2s/018umDBSBCDG2S/work/Model/sb1816x52v05.scs" section=fs_esd
include "/home/user014/model/YYKJ_model_from_24v2ag2s/018umDBSBCDG2S/work/Model/sb1816x52v05.scs" section=fs_hv_g5
include "/home/user014/model/YYKJ_model_from_24v2ag2s/018umDBSBCDG2S/work/Model/sb1816x52v05.scs" section=restypical
include "/home/user014/model/YYKJ_model_from_24v2ag2s/018umDBSBCDG2S/work/Model/sb1816x52v05.scs" section=dztypical
include "/home/user014/model/YYKJ_model_from_24v2ag2s/018umDBSBCDG2S/work/Model/sb1816x52v05.scs" section=dsbtypical
include "/home/user014/model/YYKJ_model_from_24v2ag2s/018umDBSBCDG2S/work/Model/sb1816x52v05.scs" section=diotypical
include "/home/user014/model/YYKJ_model_from_24v2ag2s/018umDBSBCDG2S/work/Model/sb1816x52v05.scs" section=fs_5
include "/home/user014/model/YYKJ_model_from_24v2ag2s/018umDBSBCDG2S/work/Model/sb1816x52v05.scs" section=mcaptypical
include "/home/user014/model/YYKJ_model_from_24v2ag2s/018umDBSBCDG2S/work/Model/sb1816x52v05.scs" section=captypical
include "/home/user014/model/YYKJ_model_from_24v2ag2s/018umDBSBCDG2S/work/Model/sb1816x52v05.scs" section=biptypical
//include "/home/user014/model/YYKJ_model_from_24v2ag2s/018umDBSBCDG2S/work/Model/sb1816x52v05.scs" section=fs_1d8
endsection fs

section sf
include "/home/user014/model/YYKJ_model_from_24v2ag2s/018umDBSBCDG2S/work/Model/sb1816x52v05.scs" section=sf_ld_g5
include "/home/user014/model/YYKJ_model_from_24v2ag2s/018umDBSBCDG2S/work/Model/sb1816x52v05.scs" section=sf_esd
include "/home/user014/model/YYKJ_model_from_24v2ag2s/018umDBSBCDG2S/work/Model/sb1816x52v05.scs" section=sf_hv_g5
include "/home/user014/model/YYKJ_model_from_24v2ag2s/018umDBSBCDG2S/work/Model/sb1816x52v05.scs" section=restypical
include "/home/user014/model/YYKJ_model_from_24v2ag2s/018umDBSBCDG2S/work/Model/sb1816x52v05.scs" section=dztypical
include "/home/user014/model/YYKJ_model_from_24v2ag2s/018umDBSBCDG2S/work/Model/sb1816x52v05.scs" section=dsbtypical
include "/home/user014/model/YYKJ_model_from_24v2ag2s/018umDBSBCDG2S/work/Model/sb1816x52v05.scs" section=diotypical
include "/home/user014/model/YYKJ_model_from_24v2ag2s/018umDBSBCDG2S/work/Model/sb1816x52v05.scs" section=sf_5
include "/home/user014/model/YYKJ_model_from_24v2ag2s/018umDBSBCDG2S/work/Model/sb1816x52v05.scs" section=mcaptypical
include "/home/user014/model/YYKJ_model_from_24v2ag2s/018umDBSBCDG2S/work/Model/sb1816x52v05.scs" section=captypical
include "/home/user014/model/YYKJ_model_from_24v2ag2s/018umDBSBCDG2S/work/Model/sb1816x52v05.scs" section=biptypical
//include "/home/user014/model/YYKJ_model_from_24v2ag2s/018umDBSBCDG2S/work/Model/sb1816x52v05.scs" section=sf_1d8
endsection sf
